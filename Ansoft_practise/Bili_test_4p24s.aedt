# Ansys Electronics Desktop project, version 2019.3
materials:
  DW310_35: permeability{HUnit=A_per_meter BUnit=tesla curve (0, 0) (58, 0.4) (60, 0.45) (62, 0.5) (64, 0.55) (68, 0.6) (72, 0.65) (75, 0.7) (78, 0.75) (84, 0.8) (92, 0.85) (100, 0.9) (107, 0.95) (116, 1) (127, 1.05) (143, 1.1) (167, 1.15) (197, 1.2) (239, 1.25) (303, 1.3) (422, 1.35) (597, 1.4) (955, 1.45) (1592, 1.5) (2389, 1.55) (3462, 1.6) (5096, 1.65) (6529, 1.7) (8262, 1.75) (10988, 1.8) (14730, 1.85) (18313, 1.9) (23090, 1.95) (30892, 2) (47771, 2.05) (74045, 2.1)} core_loss_type="Electrical Steel" core_loss_kh=179 core_loss_kc=0.403 mass_density=7650
  XG112/96: permeability{HUnit=A_per_meter BUnit=tesla curve (-520000, 0) (-501115, 0.0367032) (-481446, 0.0734063) (-460942, 0.110109) (-439549, 0.146813) (-417208, 0.183516) (-393855, 0.220219) (-369419, 0.256922) (-343822, 0.293625) (-316982, 0.330328) (-288804, 0.367032) (-256714, 0.407403) (-224625, 0.447727) (-192536, 0.488052) (-160446, 0.528376) (-128357, 0.568701) (-96267.8, 0.609025) (-64178.6, 0.64935) (-32089.3, 0.689675) (0, 0.73)} magnetic_coercivity{Magnitude=-520000A_per_meter DirComp1=1 DirComp2=0 DirComp3=0}
  XG196/96: permeability{HUnit=A_per_meter BUnit=tesla curve (-690000, 0) (-663114, 0.0487979) (-635338, 0.0975957) (-606628, 0.146394) (-576936, 0.195191) (-546211, 0.243989) (-514397, 0.292787) (-481437, 0.341585) (-447266, 0.390383) (-411817, 0.439181) (-375016, 0.487979) (-333348, 0.541105) (-291679, 0.593468) (-250011, 0.64583) (-208342, 0.698192) (-166674, 0.750554) (-125005, 0.802916) (-83337, 0.855278) (-41668.5, 0.907641) (0, 0.96)} magnetic_coercivity{Magnitude=-690000A_per_meter DirComp1=1 DirComp2=0 DirComp3=0}
  vacuum: permittivity=1
  DW310_35_2DSF0.950: permeability{HUnit=A_per_meter BUnit=tesla curve (0, 0) (58, 0.380004) (60, 0.427504) (62, 0.475004) (64, 0.522504) (68, 0.570004) (72, 0.617505) (75, 0.665005) (78, 0.712505) (84, 0.760005) (92, 0.807506) (100, 0.855006) (107, 0.902507) (116, 0.950007) (127, 0.997508) (143, 1.04501) (167, 1.09251) (197, 1.14001) (239, 1.18752) (303, 1.23502) (422, 1.28253) (597, 1.33004) (955, 1.37756) (1592, 1.4251) (2389, 1.47265) (3462, 1.52022) (5096, 1.56782) (6529, 1.61541) (8262, 1.66302) (10988, 1.71069) (14730, 1.75843) (18313, 1.80615) (23090, 1.85395) (30892, 1.90194) (47771, 1.9505) (74045, 1.99965) (336785, 2.49116)} core_loss_type="Electrical Steel" core_loss_kh=188.421 core_loss_kc=0.424211 mass_density=7267.5
  XG196/96_2DSF1.000_N: CoordinateSystemType=Cylindrical permeability=1 magnetic_coercivity{Magnitude=-726962A_per_meter DirComp1=1 DirComp2=0 DirComp3=0}
  XG196/96_2DSF1.000_S: CoordinateSystemType=Cylindrical permeability=1 magnetic_coercivity{Magnitude=-726962A_per_meter DirComp1=-1 DirComp2=0 DirComp3=0}
  copper: permeability=0.999991 conductivity=58000000 mass_density=8933
  NdFe30: CoordinateSystemType=Cylindrical permittivity=1 permeability=1.044573 conductivity=625000 magnetic_coercivity{Magnitude=-838000A_per_meter DirComp1=1 DirComp2=0 DirComp3=0} lande_g_factor=2 mass_density=7550
  NdFe31: CoordinateSystemType=Cylindrical permittivity=1 permeability=1.044573 conductivity=625000 magnetic_coercivity{Magnitude=-838000A_per_meter DirComp1=-1 DirComp2=0 DirComp3=0} lande_g_factor=2 mass_density=7550

design Maxwell2DDesign3 (Maxwell 2D, Magnetostatic, XY geometry, model units mm)
variables:
  fractions = 1
  thet = 15deg
  N = 257
  I = 0.1*sqrt(2) A
geometry:
  Band [vacuum] = user_primitive(RMxprt/Band, DiaGap=74.5mm, DiaYoke=26mm, Length=0mm, SegAngle=0deg, Fractions=1, HalfAxial=0, InfoCore=0)
  Shaft [vacuum] = user_primitive(RMxprt/Band, DiaGap=74.5mm, DiaYoke=26mm, Length=0mm, SegAngle=0deg, Fractions=1, HalfAxial=0, InfoCore=100)
  OuterRegion [vacuum] = user_primitive(RMxprt/Band, DiaGap=74.5mm, DiaYoke=120mm, Length=0mm, SegAngle=0deg, Fractions=fractions, HalfAxial=0, InfoCore=100)
  Tool = user_primitive(RMxprt/Band, DiaGap=74.5mm, DiaYoke=120mm, Length=0mm, SegAngle=0deg, Fractions=fractions, HalfAxial=0, InfoCore=1)
  Stator [DW310_35_2DSF0.950] = user_primitive(RMxprt/SlotCore, DiaGap=75mm, DiaYoke=120mm, Length=0mm, Skew=0deg, Slots=24, SlotType=1, Hs0=0.5mm, Hs01=0mm, Hs1=0mm, Hs2=6.6950329mm, Bs0=2.5mm, Bs1=5.6500582mm, Bs2=7.4128938mm, Rs=3.7064469mm, FilletType=0, HalfSlot=0, SegAngle=15deg, LenRegion=0mm, InfoCore=0)
  coil_B_6 [copper] = user_primitive(RMxprt/LapCoil, DiaGap=75mm, DiaYoke=120mm, Length=0mm, Skew=0deg, Slots=24, SlotType=1, Hs0=0.5mm, Hs1=0mm, Hs2=6.6950329mm, Bs0=2.5mm, Bs1=5.6500582mm, Bs2=7.4128938mm, Rs=3.7064469mm, FilletType=0, Layers=1, CoilPitch=2, EndExt=0mm, SpanExt=0mm, BendAngle=0deg, SegAngle=10deg, LenRegion=0mm, InfoCoil=2)
  coil_B_7, coil_A_6, coil_A_7, coil_C_7, coil_C_6, coil_B_1, coil_B, coil_A, coil_A_1, coil_C, coil_C_1, coil_B_2, coil_B_3, coil_A_2, coil_A_3, coil_C_2, coil_C_3, coil_B_4, coil_B_5, coil_A_5, coil_A_4, coil_C_5, coil_C_4 [copper] = coil_B_6.duplicate_around_axis(axis=Z, angle=15deg, total=24)
  Rotor [DW310_35_2DSF0.950] = user_primitive(RMxprt/PMCore, DiaGap=74mm, DiaYoke=26mm, Length=0mm, Poles=4, PoleType=1, Embrace=0.7, ThickMag=3.5mm, WidthMag=0mm, Offset=0mm, Bridge=0mm, Rib=0mm, LenRegion=0mm, InfoCore=0)
  Mag_0 [NdFe30] = user_primitive(RMxprt/PMCore, DiaGap=74mm, DiaYoke=26mm, Length=0mm, Poles=4, PoleType=1, Embrace=0.7, ThickMag=3.5mm, WidthMag=0mm, Offset=0mm, Bridge=0mm, Rib=0mm, LenRegion=0mm, InfoCore=2)
  Mag_1 [NdFe31], Mag_2 [NdFe30], Mag_3 [NdFe31] = Mag_0.duplicate_around_axis(axis=Z, angle=90deg, total=4)
  InnerRegion [vacuum] = user_primitive(RMxprt/PMCore, DiaGap=74mm, DiaYoke=26mm, Length=0mm, Poles=4, PoleType=1, Embrace=0.7, ThickMag=3.5mm, WidthMag=0mm, Offset=0mm, Bridge=0mm, Rib=0mm, LenRegion=0mm, InfoCore=100)
  Tool_1 = Tool.copy()
  Band.subtract(Tool_1)
  Tool_2 = Tool.copy()
  InnerRegion.subtract(Tool_2)
  Tool_3 = Tool.copy()
  Shaft.subtract(Tool_3)
  Tool_4 = Tool.copy()
  Stator.subtract(Tool_4)
  Tool_5 = Tool.copy()
  coil_B_6.subtract(Tool_5)
  Tool_6 = Tool.copy()
  coil_B_7.subtract(Tool_6)
  Tool_7 = Tool.copy()
  coil_A_6.subtract(Tool_7)
  Tool_8 = Tool.copy()
  coil_A_7.subtract(Tool_8)
  Tool_9 = Tool.copy()
  coil_C_7.subtract(Tool_9)
  Tool_10 = Tool.copy()
  coil_C_6.subtract(Tool_10)
  Tool_11 = Tool.copy()
  coil_B_1.subtract(Tool_11)
  Tool_12 = Tool.copy()
  coil_B.subtract(Tool_12)
  Tool_13 = Tool.copy()
  coil_A.subtract(Tool_13)
  Tool_14 = Tool.copy()
  coil_A_1.subtract(Tool_14)
  Tool_15 = Tool.copy()
  coil_C.subtract(Tool_15)
  Tool_16 = Tool.copy()
  coil_C_1.subtract(Tool_16)
  Tool_17 = Tool.copy()
  coil_B_2.subtract(Tool_17)
  Tool_18 = Tool.copy()
  coil_B_3.subtract(Tool_18)
  Tool_19 = Tool.copy()
  coil_A_2.subtract(Tool_19)
  Tool_20 = Tool.copy()
  coil_A_3.subtract(Tool_20)
  Tool_21 = Tool.copy()
  coil_C_2.subtract(Tool_21)
  Tool_22 = Tool.copy()
  coil_C_3.subtract(Tool_22)
  Tool_23 = Tool.copy()
  coil_B_4.subtract(Tool_23)
  Tool_24 = Tool.copy()
  coil_B_5.subtract(Tool_24)
  Tool_25 = Tool.copy()
  coil_A_5.subtract(Tool_25)
  Tool_26 = Tool.copy()
  coil_A_4.subtract(Tool_26)
  Tool_27 = Tool.copy()
  coil_C_5.subtract(Tool_27)
  Tool_28 = Tool.copy()
  coil_C_4.subtract(Tool_28)
  Tool_29 = Tool.copy()
  Rotor.subtract(Tool_29)
  Tool_30 = Tool.copy()
  Mag_0.subtract(Tool_30)
  Tool_31 = Tool.copy()
  Mag_1.subtract(Tool_31)
  Tool_32 = Tool.copy()
  Mag_2.subtract(Tool_32)
  Mag_3.subtract(Tool)
boundaries and excitations:
  VectorPotential1: Vector Potential Edges=OuterRegion.edge(at (0, 60, 0)) Value=0
  phaseA_1: Current Objects=coil_A_6 Current=N*I IsPositive=true
  phaseA_2: Current Objects=coil_A_7 Current=N*I IsPositive=true
  phaseA_3: Current Objects=coil_A_3 Current=N*I IsPositive=true
  phaseA_4: Current Objects=coil_A_2 Current=N*I IsPositive=true
  phaseB_1: Current Objects=coil_B_1 Current=-N*I/2 IsPositive=true
  phaseB_2: Current Objects=coil_B Current=-N*I/2 IsPositive=true
  phaseB_3: Current Objects=coil_B_5 Current=-N*I/2 IsPositive=true
  phaseB_4: Current Objects=coil_B_4 Current=-N*I/2 IsPositive=true
  phasex_1: Current Objects=coil_A Current=N*I IsPositive=false
  phasex_2: Current Objects=coil_A_1 Current=N*I IsPositive=false
  phasex_3: Current Objects=coil_A_4 Current=N*I IsPositive=false
  phasex_4: Current Objects=coil_A_5 Current=N*I IsPositive=false
  phaseC_1: Current Objects=coil_C Current=-N*I/2 IsPositive=true
  phaseC_2: Current Objects=coil_C_1 Current=-N*I/2 IsPositive=true
  phaseC_3: Current Objects=coil_C_4 Current=-N*I/2 IsPositive=true
  phaseC_4: Current Objects=coil_C_5 Current=-N*I/2 IsPositive=true
  phaseZ_1: Current Objects=coil_C_6 Current=-N*I/2 IsPositive=false
  phaseZ_2: Current Objects=coil_C_7 Current=-N*I/2 IsPositive=false
  phaseZ_3: Current Objects=coil_C_3 Current=-N*I/2 IsPositive=false
  phaseZ_4: Current Objects=coil_C_2 Current=-N*I/2 IsPositive=false
  phaseY_1: Current Objects=coil_B_2 Current=-N*I/2 IsPositive=false
  phaseY_2: Current Objects=coil_B_3 Current=-N*I/2 IsPositive=false
  phaseY_3: Current Objects=coil_B_7 Current=-N*I/2 IsPositive=false
  phaseY_4: Current Objects=coil_B_6 Current=-N*I/2 IsPositive=false
parameters:
  Matrix1: Matrix phaseA_1: NumberOfTurns=N ReturnPath=phasex_1; phaseA_2: NumberOfTurns=N ReturnPath=phasex_2; phaseA_3: NumberOfTurns=N ReturnPath=phasex_3; phaseA_4: NumberOfTurns=N ReturnPath=phasex_4; phaseB_1: NumberOfTurns=N ReturnPath=phaseY_1; phaseB_2: NumberOfTurns=N ReturnPath=phaseY_2; phaseB_3: NumberOfTurns=N ReturnPath=phaseY_3; phaseB_4: NumberOfTurns=N ReturnPath=phaseY_4; phaseC_1: NumberOfTurns=N ReturnPath=phaseZ_1; phaseC_2: NumberOfTurns=N ReturnPath=phaseZ_2; phaseC_3: NumberOfTurns=N ReturnPath=phaseZ_3; phaseC_4: NumberOfTurns=N ReturnPath=phaseZ_4; group PHASEA = phaseA_1..phaseA_4 (2 parallel); group PHASEB = phaseB_1..phaseB_4 (2 parallel); group PHASEC = phaseC_1..phaseC_4 (2 parallel)
mesh:
  SurfApprox_Mag: SurfApproxBased Objects=[Mag_0..Mag_3] CurvedSurfaceApproxChoice=ManualSettings SurfDev=0.037mm NormalDev=15deg
  SurfApprox_Main: SurfApproxBased Objects=[Stator, Rotor, Band, OuterRegion, InnerRegion, Shaft] CurvedSurfaceApproxChoice=ManualSettings SurfDev=0.06mm NormalDev=15deg
  initial mesh: MeshMethod=AnsoftTAU
setups:
  Setup1: Magnetostatic MaximumPasses=10 MinimumPasses=2 MinimumConvergedPasses=1 PercentRefinement=30 PercentError=1 ConstantDelta=0s NonLinearResidual=0.0001
optimetrics:
  ParametricSetup1: Parametric Sim._Setups=[Setup1]
    sweep thet: LIN 0deg 15deg 5deg
output variables:
  pos = (Moving1.Position -15 * PI/180) * 2 + PI
  cos0 = cos(pos)
  cos1 = cos(pos-2*PI/3)
  cos2 = cos(pos-4*PI/3)
  sin0 = sin(pos)
  sin1 = sin(pos-2*PI/3)
  sin2 = sin(pos-4*PI/3)
  Lad = L(PhaseA,PhaseA)*cos0 + L(PhaseA,PhaseB)*cos1 + L(PhaseA,PhaseC)*cos2
  Laq = L(PhaseA,PhaseA)*sin0 + L(PhaseA,PhaseB)*sin1 + L(PhaseA,PhaseC)*sin2
  Lbd = L(PhaseB,PhaseA)*cos0 + L(PhaseB,PhaseB)*cos1 + L(PhaseB,PhaseC)*cos2
  Lbq = L(PhaseB,PhaseA)*sin0 + L(PhaseB,PhaseB)*sin1 + L(PhaseB,PhaseC)*sin2
  Lcd = L(PhaseC,PhaseA)*cos0 + L(PhaseC,PhaseB)*cos1 + L(PhaseC,PhaseC)*cos2
  Lcq = L(PhaseC,PhaseA)*sin0 + L(PhaseC,PhaseB)*sin1 + L(PhaseC,PhaseC)*sin2
  L_d = (Lad*cos0 + Lbd*cos1 + Lcd*cos2) * 2/3
  L_q = (Laq*sin0 + Lbq*sin1 + Lcq*sin2) * 2/3
  Flux_d = (FluxLinkage(PhaseA)*cos0+FluxLinkage(PhaseB)*cos1+FluxLinkage(PhaseC)*cos2)*2/3
  Flux_q = (FluxLinkage(PhaseA)*sin0+FluxLinkage(PhaseB)*sin1+FluxLinkage(PhaseC)*sin2)*2/3
  I_d = (Current(PhaseA)*cos0 + Current(PhaseB)*cos1 + Current(PhaseC)*cos2)*2/3
  I_q = (Current(PhaseA)*sin0 + Current(PhaseB)*sin1 + Current(PhaseC)*sin2)*2/3
  Irms = sqrt(I_d^2+I_q^2)/sqrt(2)
  Pcu = 3*Irms^2*R1

design RMxprtDesign1 (RMxprt, Adjust-Speed Synchronous Machine, model units mm)
options: UDDEnabled UDD("Fractions 1")
machine:
  Machine: FrictionLoss=12W WindLoss=0W ReferenceSpeed=1500rpm NumberOfPoles=4 RotorPosition=true ControlType=3 CircuitType=L3
  Circuit: TriggerPulseWidth=120deg TransistorDrop=0V DiodeDrop=0V ModulationIndex=0 CarrierFrequencyTimes=0
  Stator: SkewWidth=0 NumberOfSlots=24 LaminationSectors=0 PressBoardThickness=0mm OuterDiameter=120mm InnerDiameter=75mm Length=65mm StackingFactor=0.95 SteelType=DW310_35 SlotType=1
  Rotor: OuterDiameter=74mm InnerDiameter=26mm Length=65mm SteelType=DW310_35 PoleType=1 StackingFactor=0.95
  Shaft:
  Stator Slot: Hs0=0.5mm Hs1=0mm Hs2=0mm Bs0=2.5mm Bs1=0mm Bs2=0mm Rs=0mm AutoDesign ToothWidth=0mm
  Stator Winding: WindingType=Whole-Coiled WindingLayers=1 ParallelBranches=2 ConductorsPerSlot=0 CoilPitch=0 EndAdjustment=0mm BaseInnerRadius=0mm TipInnerDiameter=0mm EndClearance=0mm CoilWrap=0mm SlotLiner=0.3mm WedgeThickness=0mm LayerInsulation=0mm BottomInsulation=0mm LimitedFillFactor=0.75 WdgNumberofPriodicMultipler=1 NumberOfStrands=2 WireWrap=0mm InterturnInsulation=0mm WireDiameter=0mm WireWidth=0mm WireThickness=0mm Gauge=AUTO
  Rotor Pole: Embrace=0.7 Offset=0mm ShaftDiameter=0mm Bridge=0mm Rib=0mm MagnetThickness=3.5mm MagnetWidth=0mm MagnetType=XG196/96
setups:
  Setup1: ASSM Motor RatedOutputPower=550W RatedVoltage=220V RatedSpeed=1500rpm OperatingTemperature=75cel LoadType=ConstPower RatedPowerFactor=0.75

design RMxprtDesign2 (RMxprt, Adjust-Speed Synchronous Machine, model units mm)
variables:
  thick = 3.5mm
  voltage = 220V
machine:
  Machine: FrictionLoss=12W WindLoss=0W ReferenceSpeed=1500rpm NumberOfPoles=4 RotorPosition=true ControlType=3 CircuitType=L3
  Circuit: TriggerPulseWidth=120deg TransistorDrop=0V DiodeDrop=0V ModulationIndex=0 CarrierFrequencyTimes=0
  Stator: SkewWidth=0 NumberOfSlots=24 LaminationSectors=0 PressBoardThickness=0mm OuterDiameter=120mm InnerDiameter=75mm Length=65mm StackingFactor=0.95 SteelType=DW310_35 SlotType=1
  Rotor: OuterDiameter=74mm InnerDiameter=26mm Length=65mm SteelType=DW310_35 PoleType=1 StackingFactor=0.95
  Shaft:
  Stator Slot: Hs0=0.5mm Hs1=0mm Hs2=0mm Bs0=2.5mm Bs1=0mm Bs2=0mm Rs=0mm AutoDesign ToothWidth=0mm
  Stator Winding: WindingType=Whole-Coiled WindingLayers=1 ParallelBranches=2 ConductorsPerSlot=0 CoilPitch=0 EndAdjustment=0mm BaseInnerRadius=0mm TipInnerDiameter=0mm EndClearance=0mm CoilWrap=0mm SlotLiner=0.3mm WedgeThickness=0mm LayerInsulation=0mm BottomInsulation=0mm LimitedFillFactor=0.75 WdgNumberofPriodicMultipler=1 NumberOfStrands=2 WireWrap=0mm InterturnInsulation=0mm WireDiameter=0mm WireWidth=0mm WireThickness=0mm Gauge=AUTO
  Rotor Pole: Embrace=0.7 Offset=0mm ShaftDiameter=0mm Bridge=0mm Rib=0mm MagnetThickness=thick MagnetWidth=0mm MagnetType=XG196/96
setups:
  Setup1: ASSM Motor RatedOutputPower=550W RatedVoltage=220V RatedSpeed=1500rpm OperatingTemperature=75cel LoadType=ConstPower RatedPowerFactor=0.75
  Setup2: ASSM Motor RatedOutputPower=550W RatedVoltage=voltage RatedSpeed=1500rpm OperatingTemperature=75cel LoadType=ConstPower RatedPowerFactor=0.75
optimetrics:
  ParametricSetup1: Parametric Sim._Setups=[Setup1]
    sweep thick: LIN 2.5mm 4.5mm 0.2mm
  ParametricSetup2: Parametric Sim._Setups=[Setup1, Setup2]
    sweep voltage: LIN 110V 330V 55V
reports:
  Torque Plot 1: CoggingTorqueParameter vs thick on Setup1 : Performance
  Flux Density Plot 1: AirGapFluxDensityParameter, CoggingTorqueParameter vs voltage on Setup1 : Performance [thick=2.5mm]

design RMxprtDesign3 (RMxprt, Adjust-Speed Synchronous Machine, model units mm)
options: UDDEnabled UDD("Fractions 1")
machine:
  Machine: FrictionLoss=12W WindLoss=0W ReferenceSpeed=1500rpm NumberOfPoles=4 RotorPosition=true ControlType=3 CircuitType=L3
  Circuit: TriggerPulseWidth=120deg TransistorDrop=0V DiodeDrop=0V ModulationIndex=0 CarrierFrequencyTimes=0
  Stator: SkewWidth=0 NumberOfSlots=24 LaminationSectors=0 PressBoardThickness=0mm OuterDiameter=120mm InnerDiameter=75mm Length=65mm StackingFactor=0.95 SteelType=DW310_35 SlotType=1
  Rotor: OuterDiameter=74mm InnerDiameter=26mm Length=65mm SteelType=DW310_35 PoleType=1 StackingFactor=0.95
  Shaft:
  Stator Slot: Hs0=0.5mm Hs1=0mm Hs2=0mm Bs0=2.5mm Bs1=0mm Bs2=0mm Rs=0mm AutoDesign ToothWidth=0mm
  Stator Winding: WindingType=Whole-Coiled WindingLayers=1 ParallelBranches=2 ConductorsPerSlot=0 CoilPitch=0 EndAdjustment=0mm BaseInnerRadius=0mm TipInnerDiameter=0mm EndClearance=0mm CoilWrap=0mm SlotLiner=0.3mm WedgeThickness=0mm LayerInsulation=0mm BottomInsulation=0mm LimitedFillFactor=0.75 WdgNumberofPriodicMultipler=1 NumberOfStrands=2 WireWrap=0mm InterturnInsulation=0mm WireDiameter=0mm WireWidth=0mm WireThickness=0mm Gauge=AUTO
  Rotor Pole: Embrace=0.7 Offset=0mm ShaftDiameter=0mm Bridge=0mm Rib=0mm MagnetThickness=3.5mm MagnetWidth=0mm MagnetType=XG196/96
setups:
  Setup1: ASSM Motor RatedOutputPower=550W RatedVoltage=220V RatedSpeed=1500rpm OperatingTemperature=75cel LoadType=ConstPower RatedPowerFactor=0.75
